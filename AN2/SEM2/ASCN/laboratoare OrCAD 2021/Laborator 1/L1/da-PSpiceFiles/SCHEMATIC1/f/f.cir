** Profile: "SCHEMATIC1-f"  [ C:\USERS\USER\DESKTOP\ASCN 1\L1\da-PSpiceFiles\SCHEMATIC1\f.sim ]

** Creating circuit file "f.cir"
** WARNING: THIS AUTOMATICALLY GENERATED FILE MAY BE OVERWRITTEN BY SUBSEQUENT SIMULATIONS

*Libraries:
* Profile Libraries :
.INC "C:\USERS\USER\DESKTOP\ASCN 1\L1\da-PSpiceFiles\SCHEMATIC1\f\f_profile.inc"
* Local Libraries :
* From [PSPICE NETLIST] section of C:\SPB_Data\cdssetup\OrCAD_PSpice/16.6.0/PSpice.ini file:
.lib "nomd.lib"

*Analysis directives:
.TRAN  0 1000ns 0
.OPTIONS ADVCONV
.PROBE64 V(alias(*)) I(alias(*)) W(alias(*)) D(alias(*)) NOISE(alias(*))
.INC "..\SCHEMATIC1.net"

.END
