** Profile: "SCHEMATIC1-elim_hazard"  [ C:\Users\anonim\Desktop\Facultate\Anul II\SEM II\Analiza si sinteza circuitelor numerice 1\Laborator\Laborator 4\lab4_hazard_static-pspicefiles\schematic1\elim_hazard.sim ]

** Creating circuit file "elim_hazard.cir"
** WARNING: THIS AUTOMATICALLY GENERATED FILE MAY BE OVERWRITTEN BY SUBSEQUENT SIMULATIONS

*Libraries:
* Profile Libraries :
.INC "C:\Users\anonim\Desktop\Facultate\Anul II\SEM II\Analiza si sinteza circuitelor numerice 1\Laborator\Laborator 4\lab4_hazard_"
+ "static-pspicefiles\schematic1\elim_hazard\elim_hazard_profile.inc"
* Local Libraries :
* From [PSPICE NETLIST] section of D:\Users\anonim\AppData\Roaming\SPB_Data\cdssetup\OrCAD_PSpice\17.2.0\PSpice.ini file:
.lib "nomd.lib"

*Analysis directives:
.TRAN  0 100ns 0
.OPTIONS ADVCONV
.OPTIONS DIGIOLVL= 2
.OPTIONS DIGMNTYMX= 4
.PROBE64 V(alias(*)) I(alias(*)) W(alias(*)) D(alias(*)) NOISE(alias(*))
.INC "..\SCHEMATIC1.net"

.END
